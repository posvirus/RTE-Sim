// VerilogA for fNIRS, mua_Gen, veriloga

`include "constants.vams"
`include "disciplines.vams"

module mua_Gen (HbO_in,HbR_in,Water_in,mua_out);

input HbO_in,HbR_in,Water_in;
output mua_out;

electrical HbO_in,HbR_in,Water_in,mua_out;

parameter real HbO_baseline = 0.054 from (0:inf); // The baseline concentration of HbO
parameter real HbR_baseline = 0.022 from (0:inf); // The baseline concentration of HbR
parameter real Water_baseline = 0.78 from (0:inf); // The baseline concentration of Water
parameter real wave_len = 660 from (600:1000); // The wave length of light

real cHbO,cHbR,cWater; // The actual concentration
real HbO_coef,HbR_coef,Water_coef; // The absorption coefficients

analog begin

	@(initial_step) begin
		cHbO = HbO_baseline;
		cHbR = HbR_baseline;
		cWater = Water_baseline;
	end

	cHbO = HbO_baseline + V(HbO_in);
	cHbR = HbR_baseline + V(HbR_in);
	cWater = Water_baseline + V(Water_in);

	case(wave_len) // LUT of HbO_coef
      600 : HbO_coef = 0.73696000;
      601 : HbO_coef = 0.67523960;
      602 : HbO_coef = 0.61351920;
      603 : HbO_coef = 0.55179880;
      604 : HbO_coef = 0.49007840;
      605 : HbO_coef = 0.45106558;
      606 : HbO_coef = 0.41205276;
      607 : HbO_coef = 0.39574752;
      608 : HbO_coef = 0.37944228;
      609 : HbO_coef = 0.36313704;
      610 : HbO_coef = 0.34683180;
      611 : HbO_coef = 0.33052656;
      612 : HbO_coef = 0.31422132;
      613 : HbO_coef = 0.29791608;
      614 : HbO_coef = 0.28161084;
      615 : HbO_coef = 0.26862192;
      616 : HbO_coef = 0.25563300;
      617 : HbO_coef = 0.24596040;
      618 : HbO_coef = 0.23628780;
      619 : HbO_coef = 0.22661520;
      620 : HbO_coef = 0.21694260;
      621 : HbO_coef = 0.20727000;
      622 : HbO_coef = 0.19759740;
      623 : HbO_coef = 0.18792480;
      624 : HbO_coef = 0.17825220;
      625 : HbO_coef = 0.17060624;
      626 : HbO_coef = 0.16296028;
      627 : HbO_coef = 0.15734096;
      628 : HbO_coef = 0.15172164;
      629 : HbO_coef = 0.14610232;
      630 : HbO_coef = 0.14048300;
      631 : HbO_coef = 0.13486368;
      632 : HbO_coef = 0.12924436;
      633 : HbO_coef = 0.12362504;
      634 : HbO_coef = 0.11800572;
      635 : HbO_coef = 0.11413668;
      636 : HbO_coef = 0.11026764;
      637 : HbO_coef = 0.10814888;
      638 : HbO_coef = 0.10603012;
      639 : HbO_coef = 0.10391136;
      640 : HbO_coef = 0.10179260;
      641 : HbO_coef = 0.09967384;
      642 : HbO_coef = 0.09755508;
      643 : HbO_coef = 0.09543632;
      644 : HbO_coef = 0.09331756;
      645 : HbO_coef = 0.09161334;
      646 : HbO_coef = 0.08990912;
      647 : HbO_coef = 0.08861944;
      648 : HbO_coef = 0.08732976;
      649 : HbO_coef = 0.08604008;
      650 : HbO_coef = 0.08475040;
      651 : HbO_coef = 0.08346072;
      652 : HbO_coef = 0.08217104;
      653 : HbO_coef = 0.08088136;
      654 : HbO_coef = 0.07959168;
      655 : HbO_coef = 0.07839412;
      656 : HbO_coef = 0.07719656;
      657 : HbO_coef = 0.07609112;
      658 : HbO_coef = 0.07498568;
      659 : HbO_coef = 0.07429478;
      660 : HbO_coef = 0.07360388;
      661 : HbO_coef = 0.07295904;
      662 : HbO_coef = 0.07231420;
      663 : HbO_coef = 0.07166936;
      664 : HbO_coef = 0.07102452;
      665 : HbO_coef = 0.07037968;
      666 : HbO_coef = 0.06973484;
      667 : HbO_coef = 0.06918212;
      668 : HbO_coef = 0.06862940;
      669 : HbO_coef = 0.06816880;
      670 : HbO_coef = 0.06770820;
      671 : HbO_coef = 0.06724760;
      672 : HbO_coef = 0.06678700;
      673 : HbO_coef = 0.06628034;
      674 : HbO_coef = 0.06577368;
      675 : HbO_coef = 0.06535914;
      676 : HbO_coef = 0.06494460;
      677 : HbO_coef = 0.06462218;
      678 : HbO_coef = 0.06429976;
      679 : HbO_coef = 0.06411552;
      680 : HbO_coef = 0.06393128;
      681 : HbO_coef = 0.06374704;
      682 : HbO_coef = 0.06356280;
      683 : HbO_coef = 0.06337856;
      684 : HbO_coef = 0.06319432;
      685 : HbO_coef = 0.06301008;
      686 : HbO_coef = 0.06282584;
      687 : HbO_coef = 0.06301008;
      688 : HbO_coef = 0.06319432;
      689 : HbO_coef = 0.06337856;
      690 : HbO_coef = 0.06356280;
      691 : HbO_coef = 0.06374704;
      692 : HbO_coef = 0.06393128;
      693 : HbO_coef = 0.06411552;
      694 : HbO_coef = 0.06429976;
      695 : HbO_coef = 0.06462218;
      696 : HbO_coef = 0.06494460;
      697 : HbO_coef = 0.06540520;
      698 : HbO_coef = 0.06586580;
      699 : HbO_coef = 0.06632640;
      700 : HbO_coef = 0.06678700;
      701 : HbO_coef = 0.06724760;
      702 : HbO_coef = 0.06770820;
      703 : HbO_coef = 0.06816880;
      704 : HbO_coef = 0.06862940;
      705 : HbO_coef = 0.06918212;
      706 : HbO_coef = 0.06973484;
      707 : HbO_coef = 0.07037968;
      708 : HbO_coef = 0.07102452;
      709 : HbO_coef = 0.07166936;
      710 : HbO_coef = 0.07231420;
      711 : HbO_coef = 0.07295904;
      712 : HbO_coef = 0.07360388;
      713 : HbO_coef = 0.07424872;
      714 : HbO_coef = 0.07489356;
      715 : HbO_coef = 0.07567658;
      716 : HbO_coef = 0.07645960;
      717 : HbO_coef = 0.07738080;
      718 : HbO_coef = 0.07830200;
      719 : HbO_coef = 0.07922320;
      720 : HbO_coef = 0.08014440;
      721 : HbO_coef = 0.08106560;
      722 : HbO_coef = 0.08198680;
      723 : HbO_coef = 0.08290800;
      724 : HbO_coef = 0.08382920;
      725 : HbO_coef = 0.08479646;
      726 : HbO_coef = 0.08576372;
      727 : HbO_coef = 0.08677704;
      728 : HbO_coef = 0.08779036;
      729 : HbO_coef = 0.08880368;
      730 : HbO_coef = 0.08981700;
      731 : HbO_coef = 0.09083032;
      732 : HbO_coef = 0.09184364;
      733 : HbO_coef = 0.09285696;
      734 : HbO_coef = 0.09387028;
      735 : HbO_coef = 0.09515996;
      736 : HbO_coef = 0.09644964;
      737 : HbO_coef = 0.09801568;
      738 : HbO_coef = 0.09958172;
      739 : HbO_coef = 0.10114776;
      740 : HbO_coef = 0.10271380;
      741 : HbO_coef = 0.10427984;
      742 : HbO_coef = 0.10584588;
      743 : HbO_coef = 0.10741192;
      744 : HbO_coef = 0.10897796;
      745 : HbO_coef = 0.11063612;
      746 : HbO_coef = 0.11229428;
      747 : HbO_coef = 0.11404456;
      748 : HbO_coef = 0.11579484;
      749 : HbO_coef = 0.11754512;
      750 : HbO_coef = 0.11929540;
      751 : HbO_coef = 0.12104568;
      752 : HbO_coef = 0.12279596;
      753 : HbO_coef = 0.12454624;
      754 : HbO_coef = 0.12629652;
      755 : HbO_coef = 0.12786256;
      756 : HbO_coef = 0.12942860;
      757 : HbO_coef = 0.13081040;
      758 : HbO_coef = 0.13219220;
      759 : HbO_coef = 0.13357400;
      760 : HbO_coef = 0.13495580;
      761 : HbO_coef = 0.13633760;
      762 : HbO_coef = 0.13771940;
      763 : HbO_coef = 0.13910120;
      764 : HbO_coef = 0.14048300;
      765 : HbO_coef = 0.14195692;
      766 : HbO_coef = 0.14343084;
      767 : HbO_coef = 0.14499688;
      768 : HbO_coef = 0.14656292;
      769 : HbO_coef = 0.14812896;
      770 : HbO_coef = 0.14969500;
      771 : HbO_coef = 0.15126104;
      772 : HbO_coef = 0.15282708;
      773 : HbO_coef = 0.15439312;
      774 : HbO_coef = 0.15595916;
      775 : HbO_coef = 0.15734096;
      776 : HbO_coef = 0.15872276;
      777 : HbO_coef = 0.15992032;
      778 : HbO_coef = 0.16111788;
      779 : HbO_coef = 0.16231544;
      780 : HbO_coef = 0.16351300;
      781 : HbO_coef = 0.16471056;
      782 : HbO_coef = 0.16590812;
      783 : HbO_coef = 0.16710568;
      784 : HbO_coef = 0.16830324;
      785 : HbO_coef = 0.16936262;
      786 : HbO_coef = 0.17042200;
      787 : HbO_coef = 0.17134320;
      788 : HbO_coef = 0.17226440;
      789 : HbO_coef = 0.17318560;
      790 : HbO_coef = 0.17410680;
      791 : HbO_coef = 0.17502800;
      792 : HbO_coef = 0.17594920;
      793 : HbO_coef = 0.17687040;
      794 : HbO_coef = 0.17779160;
      795 : HbO_coef = 0.17944976;
      796 : HbO_coef = 0.18110792;
      797 : HbO_coef = 0.18350304;
      798 : HbO_coef = 0.18589816;
      799 : HbO_coef = 0.18691148;
      800 : HbO_coef = 0.18792480;
      801 : HbO_coef = 0.18930660;
      802 : HbO_coef = 0.19068840;
      803 : HbO_coef = 0.19160960;
      804 : HbO_coef = 0.19253080;
      805 : HbO_coef = 0.19345200;
      806 : HbO_coef = 0.19437320;
      807 : HbO_coef = 0.19575500;
      808 : HbO_coef = 0.19713680;
      809 : HbO_coef = 0.19805800;
      810 : HbO_coef = 0.19897920;
      811 : HbO_coef = 0.19990040;
      812 : HbO_coef = 0.20082160;
      813 : HbO_coef = 0.20174280;
      814 : HbO_coef = 0.20266400;
      815 : HbO_coef = 0.20349308;
      816 : HbO_coef = 0.20432216;
      817 : HbO_coef = 0.20598032;
      818 : HbO_coef = 0.20763848;
      819 : HbO_coef = 0.20929664;
      820 : HbO_coef = 0.21095480;
      821 : HbO_coef = 0.21261296;
      822 : HbO_coef = 0.21427112;
      823 : HbO_coef = 0.21592928;
      824 : HbO_coef = 0.21758744;
      825 : HbO_coef = 0.21892318;
      826 : HbO_coef = 0.22025892;
      827 : HbO_coef = 0.22127224;
      828 : HbO_coef = 0.22228556;
      829 : HbO_coef = 0.22329888;
      830 : HbO_coef = 0.22431220;
      831 : HbO_coef = 0.22532552;
      832 : HbO_coef = 0.22633884;
      833 : HbO_coef = 0.22735216;
      834 : HbO_coef = 0.22836548;
      835 : HbO_coef = 0.22947092;
      836 : HbO_coef = 0.23057636;
      837 : HbO_coef = 0.23177392;
      838 : HbO_coef = 0.23297148;
      839 : HbO_coef = 0.23416904;
      840 : HbO_coef = 0.23536660;
      841 : HbO_coef = 0.23656416;
      842 : HbO_coef = 0.23776172;
      843 : HbO_coef = 0.23895928;
      844 : HbO_coef = 0.24015684;
      845 : HbO_coef = 0.24098592;
      846 : HbO_coef = 0.24181500;
      847 : HbO_coef = 0.24227560;
      848 : HbO_coef = 0.24273620;
      849 : HbO_coef = 0.24319680;
      850 : HbO_coef = 0.24365740;
      851 : HbO_coef = 0.24411800;
      852 : HbO_coef = 0.24457860;
      853 : HbO_coef = 0.24503920;
      854 : HbO_coef = 0.24549980;
      855 : HbO_coef = 0.24628282;
      856 : HbO_coef = 0.24706584;
      857 : HbO_coef = 0.24817128;
      858 : HbO_coef = 0.24927672;
      859 : HbO_coef = 0.25038216;
      860 : HbO_coef = 0.25148760;
      861 : HbO_coef = 0.25259304;
      862 : HbO_coef = 0.25369848;
      863 : HbO_coef = 0.25480392;
      864 : HbO_coef = 0.25590936;
      865 : HbO_coef = 0.25673844;
      866 : HbO_coef = 0.25756752;
      867 : HbO_coef = 0.25812024;
      868 : HbO_coef = 0.25867296;
      869 : HbO_coef = 0.25922568;
      870 : HbO_coef = 0.25977840;
      871 : HbO_coef = 0.26033112;
      872 : HbO_coef = 0.26088384;
      873 : HbO_coef = 0.26143656;
      874 : HbO_coef = 0.26198928;
      875 : HbO_coef = 0.26258806;
      876 : HbO_coef = 0.26318684;
      877 : HbO_coef = 0.26383168;
      878 : HbO_coef = 0.26447652;
      879 : HbO_coef = 0.26512136;
      880 : HbO_coef = 0.26576620;
      881 : HbO_coef = 0.26641104;
      882 : HbO_coef = 0.26705588;
      883 : HbO_coef = 0.26770072;
      884 : HbO_coef = 0.26834556;
      885 : HbO_coef = 0.26889828;
      886 : HbO_coef = 0.26945100;
      887 : HbO_coef = 0.26991160;
      888 : HbO_coef = 0.27037220;
      889 : HbO_coef = 0.27083280;
      890 : HbO_coef = 0.27129340;
      891 : HbO_coef = 0.27175400;
      892 : HbO_coef = 0.27221460;
      893 : HbO_coef = 0.27267520;
      894 : HbO_coef = 0.27313580;
      895 : HbO_coef = 0.27359640;
      896 : HbO_coef = 0.27405700;
      897 : HbO_coef = 0.27451760;
      898 : HbO_coef = 0.27497820;
      899 : HbO_coef = 0.27543880;
      900 : HbO_coef = 0.27589940;
      901 : HbO_coef = 0.27636000;
      902 : HbO_coef = 0.27682060;
      903 : HbO_coef = 0.27728120;
      904 : HbO_coef = 0.27774180;
      905 : HbO_coef = 0.27811028;
      906 : HbO_coef = 0.27847876;
      907 : HbO_coef = 0.27875512;
      908 : HbO_coef = 0.27903148;
      909 : HbO_coef = 0.27930784;
      910 : HbO_coef = 0.27958420;
      911 : HbO_coef = 0.27986056;
      912 : HbO_coef = 0.28013692;
      913 : HbO_coef = 0.28041328;
      914 : HbO_coef = 0.28068964;
      915 : HbO_coef = 0.28091994;
      916 : HbO_coef = 0.28115024;
      917 : HbO_coef = 0.28133448;
      918 : HbO_coef = 0.28151872;
      919 : HbO_coef = 0.28170296;
      920 : HbO_coef = 0.28188720;
      921 : HbO_coef = 0.28207144;
      922 : HbO_coef = 0.28225568;
      923 : HbO_coef = 0.28243992;
      924 : HbO_coef = 0.28262416;
      925 : HbO_coef = 0.28257810;
      926 : HbO_coef = 0.28253204;
      927 : HbO_coef = 0.28225568;
      928 : HbO_coef = 0.28197932;
      929 : HbO_coef = 0.28170296;
      930 : HbO_coef = 0.28142660;
      931 : HbO_coef = 0.28115024;
      932 : HbO_coef = 0.28087388;
      933 : HbO_coef = 0.28059752;
      934 : HbO_coef = 0.28032116;
      935 : HbO_coef = 0.28013692;
      936 : HbO_coef = 0.27995268;
      937 : HbO_coef = 0.27986056;
      938 : HbO_coef = 0.27976844;
      939 : HbO_coef = 0.27967632;
      940 : HbO_coef = 0.27958420;
      941 : HbO_coef = 0.27949208;
      942 : HbO_coef = 0.27939996;
      943 : HbO_coef = 0.27930784;
      944 : HbO_coef = 0.27921572;
      945 : HbO_coef = 0.27898542;
      946 : HbO_coef = 0.27875512;
      947 : HbO_coef = 0.27838664;
      948 : HbO_coef = 0.27801816;
      949 : HbO_coef = 0.27764968;
      950 : HbO_coef = 0.27728120;
      951 : HbO_coef = 0.27691272;
      952 : HbO_coef = 0.27654424;
      953 : HbO_coef = 0.27617576;
      954 : HbO_coef = 0.27580728;
      955 : HbO_coef = 0.27539274;
      956 : HbO_coef = 0.27497820;
      957 : HbO_coef = 0.27451760;
      958 : HbO_coef = 0.27405700;
      959 : HbO_coef = 0.27359640;
      960 : HbO_coef = 0.27313580;
      961 : HbO_coef = 0.27267520;
      962 : HbO_coef = 0.27221460;
      963 : HbO_coef = 0.27175400;
      964 : HbO_coef = 0.27129340;
      965 : HbO_coef = 0.27074068;
      966 : HbO_coef = 0.27018796;
      967 : HbO_coef = 0.26954312;
      968 : HbO_coef = 0.26889828;
      969 : HbO_coef = 0.26825344;
      970 : HbO_coef = 0.26760860;
      971 : HbO_coef = 0.26696376;
      972 : HbO_coef = 0.26631892;
      973 : HbO_coef = 0.26567408;
      974 : HbO_coef = 0.26502924;
      975 : HbO_coef = 0.26424622;
      976 : HbO_coef = 0.26346320;
      977 : HbO_coef = 0.26254200;
      978 : HbO_coef = 0.26162080;
      979 : HbO_coef = 0.26069960;
      980 : HbO_coef = 0.25977840;
      981 : HbO_coef = 0.25885720;
      982 : HbO_coef = 0.25793600;
      983 : HbO_coef = 0.25701480;
      984 : HbO_coef = 0.25609360;
      985 : HbO_coef = 0.25498816;
      986 : HbO_coef = 0.25388272;
      987 : HbO_coef = 0.25259304;
      988 : HbO_coef = 0.25130336;
      989 : HbO_coef = 0.25001368;
      990 : HbO_coef = 0.24872400;
      991 : HbO_coef = 0.24743432;
      992 : HbO_coef = 0.24614464;
      993 : HbO_coef = 0.24485496;
      994 : HbO_coef = 0.24356528;
      995 : HbO_coef = 0.24227560;
      996 : HbO_coef = 0.24098592;
      997 : HbO_coef = 0.23969624;
      998 : HbO_coef = 0.23840656;
      999 : HbO_coef = 0.23711688;
      1000 : HbO_coef = 0.23582720;
	  default : HbO_coef = 0.07360388;
	endcase

	case(wave_len) // LUT of HbR_coef
      600 : HbR_coef = 3.38015920;
      601 : HbR_coef = 3.25869890;
      602 : HbR_coef = 3.13723870;
      603 : HbR_coef = 3.01577850;
      604 : HbR_coef = 2.89431830;
      605 : HbR_coef = 2.77290410;
      606 : HbR_coef = 2.65149000;
      607 : HbR_coef = 2.53224060;
      608 : HbR_coef = 2.41299130;
      609 : HbR_coef = 2.29392620;
      610 : HbR_coef = 2.17486110;
      611 : HbR_coef = 2.07670720;
      612 : HbR_coef = 1.97855340;
      613 : HbR_coef = 1.88307100;
      614 : HbR_coef = 1.78758860;
      615 : HbR_coef = 1.73954800;
      616 : HbR_coef = 1.69150740;
      617 : HbR_coef = 1.64342080;
      618 : HbR_coef = 1.59533420;
      619 : HbR_coef = 1.54724750;
      620 : HbR_coef = 1.49916090;
      621 : HbR_coef = 1.46272740;
      622 : HbR_coef = 1.42629400;
      623 : HbR_coef = 1.39331500;
      624 : HbR_coef = 1.36033600;
      625 : HbR_coef = 1.32731100;
      626 : HbR_coef = 1.29428600;
      627 : HbR_coef = 1.26513000;
      628 : HbR_coef = 1.23597400;
      629 : HbR_coef = 1.21087130;
      630 : HbR_coef = 1.18576860;
      631 : HbR_coef = 1.16066590;
      632 : HbR_coef = 1.13556320;
      633 : HbR_coef = 1.11253320;
      634 : HbR_coef = 1.08950320;
      635 : HbR_coef = 1.07471800;
      636 : HbR_coef = 1.05993270;
      637 : HbR_coef = 1.04510140;
      638 : HbR_coef = 1.03027010;
      639 : HbR_coef = 1.01548480;
      640 : HbR_coef = 1.00069960;
      641 : HbR_coef = 0.98591430;
      642 : HbR_coef = 0.97112904;
      643 : HbR_coef = 0.95634378;
      644 : HbR_coef = 0.94155852;
      645 : HbR_coef = 0.92735822;
      646 : HbR_coef = 0.91315792;
      647 : HbR_coef = 0.90078160;
      648 : HbR_coef = 0.88840528;
      649 : HbR_coef = 0.87602896;
      650 : HbR_coef = 0.86365264;
      651 : HbR_coef = 0.85127631;
      652 : HbR_coef = 0.83889999;
      653 : HbR_coef = 0.82652367;
      654 : HbR_coef = 0.81414735;
      655 : HbR_coef = 0.80177103;
      656 : HbR_coef = 0.78939470;
      657 : HbR_coef = 0.77701838;
      658 : HbR_coef = 0.76464206;
      659 : HbR_coef = 0.75385941;
      660 : HbR_coef = 0.74307677;
      661 : HbR_coef = 0.73314163;
      662 : HbR_coef = 0.72320648;
      663 : HbR_coef = 0.71326674;
      664 : HbR_coef = 0.70332699;
      665 : HbR_coef = 0.69339185;
      666 : HbR_coef = 0.68345670;
      667 : HbR_coef = 0.67352156;
      668 : HbR_coef = 0.66358642;
      669 : HbR_coef = 0.65365128;
      670 : HbR_coef = 0.64371614;
      671 : HbR_coef = 0.63378099;
      672 : HbR_coef = 0.62384585;
      673 : HbR_coef = 0.61449567;
      674 : HbR_coef = 0.60514549;
      675 : HbR_coef = 0.59671191;
      676 : HbR_coef = 0.58827832;
      677 : HbR_coef = 0.57984473;
      678 : HbR_coef = 0.57141115;
      679 : HbR_coef = 0.56297756;
      680 : HbR_coef = 0.55454398;
      681 : HbR_coef = 0.54611039;
      682 : HbR_coef = 0.53767680;
      683 : HbR_coef = 0.52924782;
      684 : HbR_coef = 0.52081884;
      685 : HbR_coef = 0.51238526;
      686 : HbR_coef = 0.50395167;
      687 : HbR_coef = 0.49551809;
      688 : HbR_coef = 0.48708450;
      689 : HbR_coef = 0.47982544;
      690 : HbR_coef = 0.47256639;
      691 : HbR_coef = 0.46663847;
      692 : HbR_coef = 0.46071054;
      693 : HbR_coef = 0.45478723;
      694 : HbR_coef = 0.44886391;
      695 : HbR_coef = 0.44293599;
      696 : HbR_coef = 0.43700807;
      697 : HbR_coef = 0.43108015;
      698 : HbR_coef = 0.42515222;
      699 : HbR_coef = 0.41918745;
      700 : HbR_coef = 0.41322268;
      701 : HbR_coef = 0.40708749;
      702 : HbR_coef = 0.40095230;
      703 : HbR_coef = 0.39482171;
      704 : HbR_coef = 0.38869113;
      705 : HbR_coef = 0.38255594;
      706 : HbR_coef = 0.37642074;
      707 : HbR_coef = 0.37055270;
      708 : HbR_coef = 0.36468466;
      709 : HbR_coef = 0.35972860;
      710 : HbR_coef = 0.35477254;
      711 : HbR_coef = 0.34981188;
      712 : HbR_coef = 0.34485122;
      713 : HbR_coef = 0.33989516;
      714 : HbR_coef = 0.33493911;
      715 : HbR_coef = 0.32998305;
      716 : HbR_coef = 0.32502700;
      717 : HbR_coef = 0.32007094;
      718 : HbR_coef = 0.31511488;
      719 : HbR_coef = 0.31023252;
      720 : HbR_coef = 0.30535016;
      721 : HbR_coef = 0.30066126;
      722 : HbR_coef = 0.29597235;
      723 : HbR_coef = 0.29128344;
      724 : HbR_coef = 0.28659453;
      725 : HbR_coef = 0.28190102;
      726 : HbR_coef = 0.27720750;
      727 : HbR_coef = 0.27134867;
      728 : HbR_coef = 0.26548984;
      729 : HbR_coef = 0.25966325;
      730 : HbR_coef = 0.25383666;
      731 : HbR_coef = 0.25383666;
      732 : HbR_coef = 0.25383666;
      733 : HbR_coef = 0.25383666;
      734 : HbR_coef = 0.25383666;
      735 : HbR_coef = 0.25378599;
      736 : HbR_coef = 0.25373533;
      737 : HbR_coef = 0.25358794;
      738 : HbR_coef = 0.25344054;
      739 : HbR_coef = 0.25521385;
      740 : HbR_coef = 0.25698716;
      741 : HbR_coef = 0.26225643;
      742 : HbR_coef = 0.26752569;
      743 : HbR_coef = 0.27279496;
      744 : HbR_coef = 0.27806422;
      745 : HbR_coef = 0.28481662;
      746 : HbR_coef = 0.29156901;
      747 : HbR_coef = 0.29930709;
      748 : HbR_coef = 0.30704517;
      749 : HbR_coef = 0.31533597;
      750 : HbR_coef = 0.32362677;
      751 : HbR_coef = 0.33630248;
      752 : HbR_coef = 0.34897820;
      753 : HbR_coef = 0.35202276;
      754 : HbR_coef = 0.35506733;
      755 : HbR_coef = 0.35722294;
      756 : HbR_coef = 0.35937854;
      757 : HbR_coef = 0.35937854;
      758 : HbR_coef = 0.35937854;
      759 : HbR_coef = 0.35800135;
      760 : HbR_coef = 0.35662416;
      761 : HbR_coef = 0.35200894;
      762 : HbR_coef = 0.34739373;
      763 : HbR_coef = 0.34176520;
      764 : HbR_coef = 0.33613667;
      765 : HbR_coef = 0.33048971;
      766 : HbR_coef = 0.32484276;
      767 : HbR_coef = 0.31917738;
      768 : HbR_coef = 0.31351200;
      769 : HbR_coef = 0.30781898;
      770 : HbR_coef = 0.30212596;
      771 : HbR_coef = 0.29643295;
      772 : HbR_coef = 0.29073993;
      773 : HbR_coef = 0.28504692;
      774 : HbR_coef = 0.27935390;
      775 : HbR_coef = 0.27366088;
      776 : HbR_coef = 0.26796787;
      777 : HbR_coef = 0.26235315;
      778 : HbR_coef = 0.25673844;
      779 : HbR_coef = 0.25220614;
      780 : HbR_coef = 0.24767383;
      781 : HbR_coef = 0.24314153;
      782 : HbR_coef = 0.23860922;
      783 : HbR_coef = 0.23407692;
      784 : HbR_coef = 0.22954462;
      785 : HbR_coef = 0.22501231;
      786 : HbR_coef = 0.22048001;
      787 : HbR_coef = 0.21638527;
      788 : HbR_coef = 0.21229054;
      789 : HbR_coef = 0.20872089;
      790 : HbR_coef = 0.20515124;
      791 : HbR_coef = 0.20158159;
      792 : HbR_coef = 0.19801194;
      793 : HbR_coef = 0.19444229;
      794 : HbR_coef = 0.19087264;
      795 : HbR_coef = 0.18789716;
      796 : HbR_coef = 0.18492169;
      797 : HbR_coef = 0.18254960;
      798 : HbR_coef = 0.18017751;
      799 : HbR_coef = 0.17780081;
      800 : HbR_coef = 0.17542412;
      801 : HbR_coef = 0.17336523;
      802 : HbR_coef = 0.17130635;
      803 : HbR_coef = 0.17052794;
      804 : HbR_coef = 0.16974952;
      805 : HbR_coef = 0.16896650;
      806 : HbR_coef = 0.16818348;
      807 : HbR_coef = 0.16740507;
      808 : HbR_coef = 0.16662666;
      809 : HbR_coef = 0.16588509;
      810 : HbR_coef = 0.16514352;
      811 : HbR_coef = 0.16454014;
      812 : HbR_coef = 0.16393675;
      813 : HbR_coef = 0.16333337;
      814 : HbR_coef = 0.16272998;
      815 : HbR_coef = 0.16212199;
      816 : HbR_coef = 0.16151400;
      817 : HbR_coef = 0.16091061;
      818 : HbR_coef = 0.16030722;
      819 : HbR_coef = 0.16004008;
      820 : HbR_coef = 0.15977293;
      821 : HbR_coef = 0.15975450;
      822 : HbR_coef = 0.15973608;
      823 : HbR_coef = 0.15972226;
      824 : HbR_coef = 0.15970844;
      825 : HbR_coef = 0.15969002;
      826 : HbR_coef = 0.15967160;
      827 : HbR_coef = 0.15965778;
      828 : HbR_coef = 0.15964396;
      829 : HbR_coef = 0.15962554;
      830 : HbR_coef = 0.15960711;
      831 : HbR_coef = 0.15959329;
      832 : HbR_coef = 0.15957948;
      833 : HbR_coef = 0.15956105;
      834 : HbR_coef = 0.15954263;
      835 : HbR_coef = 0.15952881;
      836 : HbR_coef = 0.15951499;
      837 : HbR_coef = 0.15949657;
      838 : HbR_coef = 0.15947814;
      839 : HbR_coef = 0.15946433;
      840 : HbR_coef = 0.15945051;
      841 : HbR_coef = 0.15943208;
      842 : HbR_coef = 0.15941366;
      843 : HbR_coef = 0.15938602;
      844 : HbR_coef = 0.15935839;
      845 : HbR_coef = 0.15933536;
      846 : HbR_coef = 0.15931233;
      847 : HbR_coef = 0.15928469;
      848 : HbR_coef = 0.15925706;
      849 : HbR_coef = 0.15923403;
      850 : HbR_coef = 0.15921100;
      851 : HbR_coef = 0.15918336;
      852 : HbR_coef = 0.15915572;
      853 : HbR_coef = 0.15913269;
      854 : HbR_coef = 0.15910966;
      855 : HbR_coef = 0.15908203;
      856 : HbR_coef = 0.15905439;
      857 : HbR_coef = 0.15926166;
      858 : HbR_coef = 0.15946893;
      859 : HbR_coef = 0.15968541;
      860 : HbR_coef = 0.15990190;
      861 : HbR_coef = 0.16011838;
      862 : HbR_coef = 0.16033486;
      863 : HbR_coef = 0.16054674;
      864 : HbR_coef = 0.16075861;
      865 : HbR_coef = 0.16097509;
      866 : HbR_coef = 0.16119158;
      867 : HbR_coef = 0.16140806;
      868 : HbR_coef = 0.16162454;
      869 : HbR_coef = 0.16208975;
      870 : HbR_coef = 0.16255495;
      871 : HbR_coef = 0.16302937;
      872 : HbR_coef = 0.16350379;
      873 : HbR_coef = 0.16397821;
      874 : HbR_coef = 0.16445262;
      875 : HbR_coef = 0.16492704;
      876 : HbR_coef = 0.16540146;
      877 : HbR_coef = 0.16587588;
      878 : HbR_coef = 0.16635030;
      879 : HbR_coef = 0.16682471;
      880 : HbR_coef = 0.16729913;
      881 : HbR_coef = 0.16769064;
      882 : HbR_coef = 0.16808215;
      883 : HbR_coef = 0.16846906;
      884 : HbR_coef = 0.16885596;
      885 : HbR_coef = 0.16924747;
      886 : HbR_coef = 0.16963898;
      887 : HbR_coef = 0.17002588;
      888 : HbR_coef = 0.17041279;
      889 : HbR_coef = 0.17083193;
      890 : HbR_coef = 0.17125108;
      891 : HbR_coef = 0.17167023;
      892 : HbR_coef = 0.17208937;
      893 : HbR_coef = 0.17250852;
      894 : HbR_coef = 0.17292766;
      895 : HbR_coef = 0.17334681;
      896 : HbR_coef = 0.17376596;
      897 : HbR_coef = 0.17418510;
      898 : HbR_coef = 0.17460425;
      899 : HbR_coef = 0.17502800;
      900 : HbR_coef = 0.17545175;
      901 : HbR_coef = 0.17582023;
      902 : HbR_coef = 0.17618871;
      903 : HbR_coef = 0.17646507;
      904 : HbR_coef = 0.17674143;
      905 : HbR_coef = 0.17701319;
      906 : HbR_coef = 0.17728494;
      907 : HbR_coef = 0.17755669;
      908 : HbR_coef = 0.17782845;
      909 : HbR_coef = 0.17810481;
      910 : HbR_coef = 0.17838117;
      911 : HbR_coef = 0.17865292;
      912 : HbR_coef = 0.17892468;
      913 : HbR_coef = 0.17909510;
      914 : HbR_coef = 0.17926552;
      915 : HbR_coef = 0.17922407;
      916 : HbR_coef = 0.17918261;
      917 : HbR_coef = 0.17914576;
      918 : HbR_coef = 0.17910892;
      919 : HbR_coef = 0.17906746;
      920 : HbR_coef = 0.17902601;
      921 : HbR_coef = 0.17898916;
      922 : HbR_coef = 0.17895231;
      923 : HbR_coef = 0.17890625;
      924 : HbR_coef = 0.17886019;
      925 : HbR_coef = 0.17836735;
      926 : HbR_coef = 0.17787451;
      927 : HbR_coef = 0.17738167;
      928 : HbR_coef = 0.17688882;
      929 : HbR_coef = 0.17640059;
      930 : HbR_coef = 0.17591235;
      931 : HbR_coef = 0.17458122;
      932 : HbR_coef = 0.17325008;
      933 : HbR_coef = 0.17155508;
      934 : HbR_coef = 0.16986007;
      935 : HbR_coef = 0.16816967;
      936 : HbR_coef = 0.16647926;
      937 : HbR_coef = 0.16478426;
      938 : HbR_coef = 0.16308925;
      939 : HbR_coef = 0.16139424;
      940 : HbR_coef = 0.15969923;
      941 : HbR_coef = 0.15800422;
      942 : HbR_coef = 0.15630922;
      943 : HbR_coef = 0.15421349;
      944 : HbR_coef = 0.15211776;
      945 : HbR_coef = 0.14987924;
      946 : HbR_coef = 0.14764072;
      947 : HbR_coef = 0.14540221;
      948 : HbR_coef = 0.14316369;
      949 : HbR_coef = 0.14092978;
      950 : HbR_coef = 0.13869587;
      951 : HbR_coef = 0.13652645;
      952 : HbR_coef = 0.13435702;
      953 : HbR_coef = 0.13268965;
      954 : HbR_coef = 0.13102228;
      955 : HbR_coef = 0.12935951;
      956 : HbR_coef = 0.12769674;
      957 : HbR_coef = 0.12603398;
      958 : HbR_coef = 0.12437121;
      959 : HbR_coef = 0.12270384;
      960 : HbR_coef = 0.12103647;
      961 : HbR_coef = 0.11937370;
      962 : HbR_coef = 0.11771094;
      963 : HbR_coef = 0.11589617;
      964 : HbR_coef = 0.11408141;
      965 : HbR_coef = 0.11154350;
      966 : HbR_coef = 0.10900560;
      967 : HbR_coef = 0.10647230;
      968 : HbR_coef = 0.10393900;
      969 : HbR_coef = 0.10140570;
      970 : HbR_coef = 0.09887240;
      971 : HbR_coef = 0.09725569;
      972 : HbR_coef = 0.09563898;
      973 : HbR_coef = 0.09414203;
      974 : HbR_coef = 0.09264508;
      975 : HbR_coef = 0.09114906;
      976 : HbR_coef = 0.08965303;
      977 : HbR_coef = 0.08800131;
      978 : HbR_coef = 0.08634960;
      979 : HbR_coef = 0.08458919;
      980 : HbR_coef = 0.08282878;
      981 : HbR_coef = 0.08106882;
      982 : HbR_coef = 0.07930887;
      983 : HbR_coef = 0.07754846;
      984 : HbR_coef = 0.07578804;
      985 : HbR_coef = 0.07402763;
      986 : HbR_coef = 0.07226722;
      987 : HbR_coef = 0.07050681;
      988 : HbR_coef = 0.06874639;
      989 : HbR_coef = 0.06698598;
      990 : HbR_coef = 0.06522557;
      991 : HbR_coef = 0.06346515;
      992 : HbR_coef = 0.06170474;
      993 : HbR_coef = 0.05994479;
      994 : HbR_coef = 0.05818483;
      995 : HbR_coef = 0.05642442;
      996 : HbR_coef = 0.05466401;
      997 : HbR_coef = 0.05290359;
      998 : HbR_coef = 0.05114318;
      999 : HbR_coef = 0.04938277;
      1000 : HbR_coef = 0.04762235;
	  default : HbR_coef = 0.74307677;
	endcase

	case(wave_len) // LUT of Water_coef
	  600 : Water_coef = 0.00023000;
      601 : Water_coef = 0.00023400;
      602 : Water_coef = 0.00023800;
      603 : Water_coef = 0.00024150;
      604 : Water_coef = 0.00024500;
      605 : Water_coef = 0.00024800;
      606 : Water_coef = 0.00025100;
      607 : Water_coef = 0.00025350;
      608 : Water_coef = 0.00025600;
      609 : Water_coef = 0.00025800;
      610 : Water_coef = 0.00026000;
      611 : Water_coef = 0.00026200;
      612 : Water_coef = 0.00026400;
      613 : Water_coef = 0.00026600;
      614 : Water_coef = 0.00026800;
      615 : Water_coef = 0.00026950;
      616 : Water_coef = 0.00027100;
      617 : Water_coef = 0.00027200;
      618 : Water_coef = 0.00027300;
      619 : Water_coef = 0.00027400;
      620 : Water_coef = 0.00027500;
      621 : Water_coef = 0.00027600;
      622 : Water_coef = 0.00027700;
      623 : Water_coef = 0.00027800;
      624 : Water_coef = 0.00027900;
      625 : Water_coef = 0.00028000;
      626 : Water_coef = 0.00028100;
      627 : Water_coef = 0.00028150;
      628 : Water_coef = 0.00028200;
      629 : Water_coef = 0.00028300;
      630 : Water_coef = 0.00028400;
      631 : Water_coef = 0.00028500;
      632 : Water_coef = 0.00028600;
      633 : Water_coef = 0.00028700;
      634 : Water_coef = 0.00028800;
      635 : Water_coef = 0.00028900;
      636 : Water_coef = 0.00029000;
      637 : Water_coef = 0.00029150;
      638 : Water_coef = 0.00029300;
      639 : Water_coef = 0.00029450;
      640 : Water_coef = 0.00029600;
      641 : Water_coef = 0.00029750;
      642 : Water_coef = 0.00029900;
      643 : Water_coef = 0.00030150;
      644 : Water_coef = 0.00030400;
      645 : Water_coef = 0.00030600;
      646 : Water_coef = 0.00030800;
      647 : Water_coef = 0.00031100;
      648 : Water_coef = 0.00031400;
      649 : Water_coef = 0.00031700;
      650 : Water_coef = 0.00032000;
      651 : Water_coef = 0.00032350;
      652 : Water_coef = 0.00032700;
      653 : Water_coef = 0.00033100;
      654 : Water_coef = 0.00033500;
      655 : Water_coef = 0.00033900;
      656 : Water_coef = 0.00034300;
      657 : Water_coef = 0.00034750;
      658 : Water_coef = 0.00035200;
      659 : Water_coef = 0.00035650;
      660 : Water_coef = 0.00036100;
      661 : Water_coef = 0.00036500;
      662 : Water_coef = 0.00036900;
      663 : Water_coef = 0.00037350;
      664 : Water_coef = 0.00037800;
      665 : Water_coef = 0.00038200;
      666 : Water_coef = 0.00038600;
      667 : Water_coef = 0.00039000;
      668 : Water_coef = 0.00039400;
      669 : Water_coef = 0.00039750;
      670 : Water_coef = 0.00040100;
      671 : Water_coef = 0.00040450;
      672 : Water_coef = 0.00040800;
      673 : Water_coef = 0.00041050;
      674 : Water_coef = 0.00041300;
      675 : Water_coef = 0.00041500;
      676 : Water_coef = 0.00041700;
      677 : Water_coef = 0.00041850;
      678 : Water_coef = 0.00042000;
      679 : Water_coef = 0.00042150;
      680 : Water_coef = 0.00042300;
      681 : Water_coef = 0.00042450;
      682 : Water_coef = 0.00042600;
      683 : Water_coef = 0.00042850;
      684 : Water_coef = 0.00043100;
      685 : Water_coef = 0.00043450;
      686 : Water_coef = 0.00043800;
      687 : Water_coef = 0.00044250;
      688 : Water_coef = 0.00044700;
      689 : Water_coef = 0.00045350;
      690 : Water_coef = 0.00046000;
      691 : Water_coef = 0.00046850;
      692 : Water_coef = 0.00047700;
      693 : Water_coef = 0.00048800;
      694 : Water_coef = 0.00049900;
      695 : Water_coef = 0.00051250;
      696 : Water_coef = 0.00052600;
      697 : Water_coef = 0.00054250;
      698 : Water_coef = 0.00055900;
      699 : Water_coef = 0.00057950;
      700 : Water_coef = 0.00060000;
      701 : Water_coef = 0.00062400;
      702 : Water_coef = 0.00064800;
      703 : Water_coef = 0.00067550;
      704 : Water_coef = 0.00070300;
      705 : Water_coef = 0.00073450;
      706 : Water_coef = 0.00076600;
      707 : Water_coef = 0.00080000;
      708 : Water_coef = 0.00083400;
      709 : Water_coef = 0.00087100;
      710 : Water_coef = 0.00090800;
      711 : Water_coef = 0.00094750;
      712 : Water_coef = 0.00098700;
      713 : Water_coef = 0.00102850;
      714 : Water_coef = 0.00107000;
      715 : Water_coef = 0.00111400;
      716 : Water_coef = 0.00115800;
      717 : Water_coef = 0.00120350;
      718 : Water_coef = 0.00124900;
      719 : Water_coef = 0.00129650;
      720 : Water_coef = 0.00134400;
      721 : Water_coef = 0.00139250;
      722 : Water_coef = 0.00144100;
      723 : Water_coef = 0.00149050;
      724 : Water_coef = 0.00154000;
      725 : Water_coef = 0.00159000;
      726 : Water_coef = 0.00164000;
      727 : Water_coef = 0.00169100;
      728 : Water_coef = 0.00174200;
      729 : Water_coef = 0.00179250;
      730 : Water_coef = 0.00184300;
      731 : Water_coef = 0.00189250;
      732 : Water_coef = 0.00194200;
      733 : Water_coef = 0.00199050;
      734 : Water_coef = 0.00203900;
      735 : Water_coef = 0.00208600;
      736 : Water_coef = 0.00213300;
      737 : Water_coef = 0.00217750;
      738 : Water_coef = 0.00222200;
      739 : Water_coef = 0.00226350;
      740 : Water_coef = 0.00230500;
      741 : Water_coef = 0.00234350;
      742 : Water_coef = 0.00238200;
      743 : Water_coef = 0.00241650;
      744 : Water_coef = 0.00245100;
      745 : Water_coef = 0.00248100;
      746 : Water_coef = 0.00251100;
      747 : Water_coef = 0.00253600;
      748 : Water_coef = 0.00256100;
      749 : Water_coef = 0.00258050;
      750 : Water_coef = 0.00260000;
      751 : Water_coef = 0.00261400;
      752 : Water_coef = 0.00262800;
      753 : Water_coef = 0.00263600;
      754 : Water_coef = 0.00264400;
      755 : Water_coef = 0.00264700;
      756 : Water_coef = 0.00265000;
      757 : Water_coef = 0.00264900;
      758 : Water_coef = 0.00264800;
      759 : Water_coef = 0.00264250;
      760 : Water_coef = 0.00263700;
      761 : Water_coef = 0.00262800;
      762 : Water_coef = 0.00261900;
      763 : Water_coef = 0.00260750;
      764 : Water_coef = 0.00259600;
      765 : Water_coef = 0.00258150;
      766 : Water_coef = 0.00256700;
      767 : Water_coef = 0.00255050;
      768 : Water_coef = 0.00253400;
      769 : Water_coef = 0.00251600;
      770 : Water_coef = 0.00249800;
      771 : Water_coef = 0.00247850;
      772 : Water_coef = 0.00245900;
      773 : Water_coef = 0.00243950;
      774 : Water_coef = 0.00242000;
      775 : Water_coef = 0.00240000;
      776 : Water_coef = 0.00238000;
      777 : Water_coef = 0.00236050;
      778 : Water_coef = 0.00234100;
      779 : Water_coef = 0.00232200;
      780 : Water_coef = 0.00230300;
      781 : Water_coef = 0.00228400;
      782 : Water_coef = 0.00226500;
      783 : Water_coef = 0.00224650;
      784 : Water_coef = 0.00222800;
      785 : Water_coef = 0.00221050;
      786 : Water_coef = 0.00219300;
      787 : Water_coef = 0.00217600;
      788 : Water_coef = 0.00215900;
      789 : Water_coef = 0.00214300;
      790 : Water_coef = 0.00212700;
      791 : Water_coef = 0.00211200;
      792 : Water_coef = 0.00209700;
      793 : Water_coef = 0.00208300;
      794 : Water_coef = 0.00206900;
      795 : Water_coef = 0.00205600;
      796 : Water_coef = 0.00204300;
      797 : Water_coef = 0.00203150;
      798 : Water_coef = 0.00202000;
      799 : Water_coef = 0.00201000;
      800 : Water_coef = 0.00200000;
      801 : Water_coef = 0.00199150;
      802 : Water_coef = 0.00198300;
      803 : Water_coef = 0.00197700;
      804 : Water_coef = 0.00197100;
      805 : Water_coef = 0.00196850;
      806 : Water_coef = 0.00196600;
      807 : Water_coef = 0.00196800;
      808 : Water_coef = 0.00197000;
      809 : Water_coef = 0.00197800;
      810 : Water_coef = 0.00198600;
      811 : Water_coef = 0.00200050;
      812 : Water_coef = 0.00201500;
      813 : Water_coef = 0.00204000;
      814 : Water_coef = 0.00206500;
      815 : Water_coef = 0.00210200;
      816 : Water_coef = 0.00213900;
      817 : Water_coef = 0.00219250;
      818 : Water_coef = 0.00224600;
      819 : Water_coef = 0.00231850;
      820 : Water_coef = 0.00239100;
      821 : Water_coef = 0.00248000;
      822 : Water_coef = 0.00256900;
      823 : Water_coef = 0.00265300;
      824 : Water_coef = 0.00273700;
      825 : Water_coef = 0.00278950;
      826 : Water_coef = 0.00284200;
      827 : Water_coef = 0.00286150;
      828 : Water_coef = 0.00288100;
      829 : Water_coef = 0.00289400;
      830 : Water_coef = 0.00290700;
      831 : Water_coef = 0.00293450;
      832 : Water_coef = 0.00296200;
      833 : Water_coef = 0.00300600;
      834 : Water_coef = 0.00305000;
      835 : Water_coef = 0.00310900;
      836 : Water_coef = 0.00316800;
      837 : Water_coef = 0.00323900;
      838 : Water_coef = 0.00331000;
      839 : Water_coef = 0.00339050;
      840 : Water_coef = 0.00347100;
      841 : Water_coef = 0.00355800;
      842 : Water_coef = 0.00364500;
      843 : Water_coef = 0.00373500;
      844 : Water_coef = 0.00382500;
      845 : Water_coef = 0.00391250;
      846 : Water_coef = 0.00400000;
      847 : Water_coef = 0.00408100;
      848 : Water_coef = 0.00416200;
      849 : Water_coef = 0.00423100;
      850 : Water_coef = 0.00430000;
      851 : Water_coef = 0.00435450;
      852 : Water_coef = 0.00440900;
      853 : Water_coef = 0.00445050;
      854 : Water_coef = 0.00449200;
      855 : Water_coef = 0.00452600;
      856 : Water_coef = 0.00456000;
      857 : Water_coef = 0.00458900;
      858 : Water_coef = 0.00461800;
      859 : Water_coef = 0.00464700;
      860 : Water_coef = 0.00467600;
      861 : Water_coef = 0.00470850;
      862 : Water_coef = 0.00474100;
      863 : Water_coef = 0.00478000;
      864 : Water_coef = 0.00481900;
      865 : Water_coef = 0.00486800;
      866 : Water_coef = 0.00491700;
      867 : Water_coef = 0.00497950;
      868 : Water_coef = 0.00504200;
      869 : Water_coef = 0.00512100;
      870 : Water_coef = 0.00520000;
      871 : Water_coef = 0.00529300;
      872 : Water_coef = 0.00538600;
      873 : Water_coef = 0.00546700;
      874 : Water_coef = 0.00554800;
      875 : Water_coef = 0.00558650;
      876 : Water_coef = 0.00562500;
      877 : Water_coef = 0.00562300;
      878 : Water_coef = 0.00562100;
      879 : Water_coef = 0.00560950;
      880 : Water_coef = 0.00559800;
      881 : Water_coef = 0.00560500;
      882 : Water_coef = 0.00561200;
      883 : Water_coef = 0.00564050;
      884 : Water_coef = 0.00566900;
      885 : Water_coef = 0.00571650;
      886 : Water_coef = 0.00576400;
      887 : Water_coef = 0.00582750;
      888 : Water_coef = 0.00589100;
      889 : Water_coef = 0.00596700;
      890 : Water_coef = 0.00604300;
      891 : Water_coef = 0.00612850;
      892 : Water_coef = 0.00621400;
      893 : Water_coef = 0.00630250;
      894 : Water_coef = 0.00639100;
      895 : Water_coef = 0.00647400;
      896 : Water_coef = 0.00655700;
      897 : Water_coef = 0.00662800;
      898 : Water_coef = 0.00669900;
      899 : Water_coef = 0.00674950;
      900 : Water_coef = 0.00680000;
      901 : Water_coef = 0.00682750;
      902 : Water_coef = 0.00685500;
      903 : Water_coef = 0.00687450;
      904 : Water_coef = 0.00689400;
      905 : Water_coef = 0.00692350;
      906 : Water_coef = 0.00695300;
      907 : Water_coef = 0.00701300;
      908 : Water_coef = 0.00707300;
      909 : Water_coef = 0.00718200;
      910 : Water_coef = 0.00729100;
      911 : Water_coef = 0.00746750;
      912 : Water_coef = 0.00764400;
      913 : Water_coef = 0.00790100;
      914 : Water_coef = 0.00815800;
      915 : Water_coef = 0.00850900;
      916 : Water_coef = 0.00886000;
      917 : Water_coef = 0.00931700;
      918 : Water_coef = 0.00977400;
      919 : Water_coef = 0.01035050;
      920 : Water_coef = 0.01092700;
      921 : Water_coef = 0.01161550;
      922 : Water_coef = 0.01230400;
      923 : Water_coef = 0.01301800;
      924 : Water_coef = 0.01373200;
      925 : Water_coef = 0.01437100;
      926 : Water_coef = 0.01501000;
      927 : Water_coef = 0.01557150;
      928 : Water_coef = 0.01613300;
      929 : Water_coef = 0.01671450;
      930 : Water_coef = 0.01729600;
      931 : Water_coef = 0.01798250;
      932 : Water_coef = 0.01866900;
      933 : Water_coef = 0.01948100;
      934 : Water_coef = 0.02029300;
      935 : Water_coef = 0.02123350;
      936 : Water_coef = 0.02217400;
      937 : Water_coef = 0.02324650;
      938 : Water_coef = 0.02431900;
      939 : Water_coef = 0.02552800;
      940 : Water_coef = 0.02673700;
      941 : Water_coef = 0.02806900;
      942 : Water_coef = 0.02940100;
      943 : Water_coef = 0.03077600;
      944 : Water_coef = 0.03215100;
      945 : Water_coef = 0.03347350;
      946 : Water_coef = 0.03479600;
      947 : Water_coef = 0.03596950;
      948 : Water_coef = 0.03714300;
      949 : Water_coef = 0.03807150;
      950 : Water_coef = 0.03900000;
      951 : Water_coef = 0.03961800;
      952 : Water_coef = 0.04023600;
      953 : Water_coef = 0.04060400;
      954 : Water_coef = 0.04097200;
      955 : Water_coef = 0.04118050;
      956 : Water_coef = 0.04138900;
      957 : Water_coef = 0.04153000;
      958 : Water_coef = 0.04167100;
      959 : Water_coef = 0.04183550;
      960 : Water_coef = 0.04200000;
      961 : Water_coef = 0.04225600;
      962 : Water_coef = 0.04251200;
      963 : Water_coef = 0.04283650;
      964 : Water_coef = 0.04316100;
      965 : Water_coef = 0.04350750;
      966 : Water_coef = 0.04385400;
      967 : Water_coef = 0.04417600;
      968 : Water_coef = 0.04449800;
      969 : Water_coef = 0.04474900;
      970 : Water_coef = 0.04500000;
      971 : Water_coef = 0.04513300;
      972 : Water_coef = 0.04526600;
      973 : Water_coef = 0.04523000;
      974 : Water_coef = 0.04519400;
      975 : Water_coef = 0.04494250;
      976 : Water_coef = 0.04469100;
      977 : Water_coef = 0.04427500;
      978 : Water_coef = 0.04385900;
      979 : Water_coef = 0.04342950;
      980 : Water_coef = 0.04300000;
      981 : Water_coef = 0.04267900;
      982 : Water_coef = 0.04235800;
      983 : Water_coef = 0.04213750;
      984 : Water_coef = 0.04191700;
      985 : Water_coef = 0.04175700;
      986 : Water_coef = 0.04159700;
      987 : Water_coef = 0.04145750;
      988 : Water_coef = 0.04131800;
      989 : Water_coef = 0.04115900;
      990 : Water_coef = 0.04100000;
      991 : Water_coef = 0.04078100;
      992 : Water_coef = 0.04056200;
      993 : Water_coef = 0.04024250;
      994 : Water_coef = 0.03992300;
      995 : Water_coef = 0.03946300;
      996 : Water_coef = 0.03900300;
      997 : Water_coef = 0.03836250;
      998 : Water_coef = 0.03772200;
      999 : Water_coef = 0.03686100;
      1000 : Water_coef = 0.03600000;
	  default : Water_coef = 0.00036100;
	endcase

	V(mua_out) <+ cHbO*HbO_coef+cHbR*HbR_coef+cWater*Water_coef;

end

endmodule
